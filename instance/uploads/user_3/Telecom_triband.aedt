# Ansys Electronics Desktop project, version 2024.2
materials:
  FR4_epoxy: permittivity=4.4 dielectric_loss_tangent=0.02
  aluminum: permeability=1.000021 conductivity=38000000
  brass: conductivity=15000000
  copper: permeability=0.999991 conductivity=58000000
  vacuum: permittivity=1

design Banda 2A8+2B12+2C12 (HFSS, HFSS Modal Network, model units mm)
options: Save_Adaptive_support_files open_region{BoundaryType=0 OpFreq=2.19GHz}
variables:
  parede = 1.6mm
  larg_dip = 15.7mm
  Chanfer_1 = 2.5mm
  comp_dip = 35.5mm
  comp_refletor = 80mm
  dist_central = 5mm
  comp_PCB = 37.5mm
  dist_refletor = 20mm
  cabo = 2.2mm
  pos_curto_1 = 1.3mm
  larg_curto = 1.3mm
  comp_curto_1 = 3.7mm
  loop_curto = 2.8mm
  parede_inf = 4.5mm
  Chanfer_2 = 3.8mm
  larg_corte = 0.7mm
  comp_curto_2 = 5.5mm
  refl_lat = 16mm
  X1 = 110.6mm
  Y1 = 32.8mm
  dim_ref_3 = 6.6mm
  port3g1 = 0W
  port3g2 = 0W
  port2g1 = 1W
  port2g2 = 1W
  port1g1 = 0W
  port1g2 = 0W
  port1g3 = 0W
  port1g4 = 0W
  port2g3 = 1W
  port2g4 = 1W
  port2g5 = 1W
  port2g6 = 1W
  port2g7 = 1W
  port2g8 = 1W
  port3g4 = 0W
  port3g5 = 0W
  port3g6 = 0W
  port3g7 = 0W
  port3g8 = 0W
geometry:
  Polyline1 = imported_body(C:\Users\Projeto\Desktop\Banda1+2.sat)
  Box1 [FR4_epoxy] = imported_body(C:\Users\Projeto\Desktop\Banda1+2.sat)
  Cylinder1, Cylinder3, Cylinder3_1, Cylinder1_1 [aluminum] = imported_body(C:\Users\Projeto\Desktop\Banda1+2.sat)
  Rectangle2, Box2, Rectangle5, Rectangle10 = imported_body(C:\Users\Projeto\Desktop\Banda1+2.sat)
  Cylinder5, Cylinder5_1, Cylinder1_5, Cylinder1_1_2, Cylinder3_4, Cylinder3_1_3, Cylinder5_3, Cylinder5_1_2 [aluminum] = imported_body(C:\Users\Projeto\Desktop\Banda1+2.sat)
  Box1_1 [FR4_epoxy] = imported_body(C:\Users\Projeto\Desktop\Banda1+2.sat)
  Polyline1_4, Rectangle2_1, Rectangle5_1, Rectangle10_1, Polyline2 = imported_body(C:\Users\Projeto\Desktop\Banda1+2.sat)
  Box3 [FR4_epoxy] = imported_body(C:\Users\Projeto\Desktop\Banda1+2.sat)
  Cylinder6, Cylinder7, Cylinder3_5, Cylinder1_6 [aluminum] = imported_body(C:\Users\Projeto\Desktop\Banda1+2.sat)
  Rectangle11, Cylinder2_ObjectFromFace1, Cylinder2_1_ObjectFromFace1, Rectangle12, Rectangle13 = imported_body(C:\Users\Projeto\Desktop\Banda1+2.sat)
  Cylinder8, Cylinder5_4 [aluminum] = imported_body(C:\Users\Projeto\Desktop\Banda1+2.sat)
  Cylinder2_ObjectFromFace1_1 = imported_body(C:\Users\Projeto\Desktop\Banda1+2.sat)
  Cylinder1_6_1, Cylinder3_5_1, Cylinder6_1, Cylinder7_1, Cylinder5_4_1, Cylinder8_1 [aluminum] = imported_body(C:\Users\Projeto\Desktop\Banda1+2.sat)
  Box3_4 [FR4_epoxy] = imported_body(C:\Users\Projeto\Desktop\Banda1+2.sat)
  Polyline2_4, Rectangle11_1, Rectangle12_1, Rectangle13_1, Cylinder2_1_ObjectFromFace1_1 = imported_body(C:\Users\Projeto\Desktop\Banda1+2.sat)
  Polyline3 = polyline(z=0mm, xy: (0mm, -larg_dip/2) (0mm, larg_dip/2) (comp_dip/2, larg_dip/2) (comp_dip/2, -larg_dip/2) (0mm, -larg_dip/2), closed, covered)
  Polyline3.chamfer(Vertices=Polyline3.vertex(at (17.75, -7.85, 0), at (17.75, 7.85, 0)) LeftDistance=Chanfer_1+parede/2 RightDistance=Chanfer_1+parede/2 ChamferType=Symmetric)
  Polyline1_1, Polyline1_2, Polyline1_3 = Polyline3.duplicate_around_axis(axis=Z, angle=90deg, total=4)
  Polyline3.move(dist_central/2, 0mm, 0mm)
  Polyline1_1.move(0mm, dist_central/2, 0mm)
  Polyline1_2.move(-dist_central/2, 0mm, 0mm)
  Polyline1_3.move(0mm, -dist_central/2, 0mm)
  Polyline3.unite(Polyline1_1, Polyline1_2, Polyline1_3)
  Polyline4 = polyline(z=0mm, xy: (parede_inf, -larg_dip/2+parede) (parede_inf, larg_dip/2-parede) (comp_dip/2-parede, larg_dip/2-parede) (comp_dip/2-parede, -larg_dip/2+parede) (parede_inf, -larg_dip/2+parede), closed, covered)
  Polyline4.chamfer(Vertices=Polyline4.vertex(at (16.15, -6.25, 0), at (16.15, 6.25, 0)) LeftDistance=Chanfer_1 RightDistance=Chanfer_1 ChamferType=Symmetric)
  Polyline4.chamfer(Vertices=Polyline4.vertex(at (4.5, -6.25, 0), at (4.5, 6.25, 0)) LeftDistance=Chanfer_2 RightDistance=Chanfer_2 ChamferType=Symmetric)
  Polyline2_1, Polyline2_2, Polyline2_3 = Polyline4.duplicate_around_axis(axis=Z, angle=90deg, total=4)
  Polyline4.move(dist_central/2, 0mm, 0mm)
  Polyline2_1.move(0mm, dist_central/2, 0mm)
  Polyline2_2.move(-dist_central/2, 0mm, 0mm)
  Polyline2_3.move(0mm, -dist_central/2, 0mm)
  Polyline3.subtract(Polyline4, Polyline2_1, Polyline2_2, Polyline2_3)
  Rectangle1 = rectangle(corner=(-larg_corte/2, -30mm, 0mm), x_size=larg_corte, y_size=60mm)
  Rectangle1.rotate(axis=Z, angle=45deg)
  Rectangle1_1 = Rectangle1.duplicate_around_axis(axis=Z, angle=90deg, total=2)
  Polyline3.subtract(Rectangle1, Rectangle1_1)
  Cylinder10 [brass] = cylinder(axis=Z, base_centre=(0mm, 0mm, 0mm), radius=3.5mm/2, height=-dist_refletor)
  Cylinder10.move(0mm, -dist_central/2-cabo, 0mm)
  Cylinder3_6 [brass] = Cylinder10.duplicate_around_axis(axis=Z, angle=90deg, total=2)
  Cylinder3_1_1 = Cylinder3_6.copy()
  Polyline3.subtract(Cylinder3_1_1)
  Cylinder3_2 = Cylinder10.copy()
  Polyline3.subtract(Cylinder3_2)
  Polyline3.rotate(axis=Z, angle=45deg)
  Polyline1_5 = Polyline3.duplicate_along_line(step=(comp_refletor-1.2mm, 0mm, 0mm), total=2)
  Box4 [FR4_epoxy] = box(corner=(-comp_PCB/2, -comp_PCB/2, 0), size=(comp_PCB, comp_PCB, 1.2mm))
  Box4.rotate(axis=Z, angle=45deg)
  Cylinder9 [brass] = cylinder(axis=Z, base_centre=(0mm, 0mm, 1.5mm), radius=1mm/2, height=-dist_refletor-1.5mm)
  Cylinder9.move(0mm, -dist_central/2-cabo, 0mm)
  Cylinder1_7 [brass] = Cylinder9.duplicate_around_axis(axis=Z, angle=90deg, total=2)
  Cylinder1_2 = Cylinder9.copy()
  Cylinder1_1_1 = Cylinder1_7.copy()
  Box4.subtract(Cylinder1_2, Cylinder1_1_1)
  Cylinder11 [copper] = cylinder(axis=Z, base_centre=(loop_curto/2, 0mm, 0mm), radius=1mm/2, height=1.2mm)
  Cylinder5_5 [copper] = Cylinder11.duplicate_mirror(point=(0mm, 0mm, 0mm), normal=(-1mm, 0mm, 0mm))
  Cylinder5_2 = Cylinder11.copy()
  Cylinder5_1_1 = Cylinder5_5.copy()
  Box4.subtract(Cylinder5_2, Cylinder5_1_1)
  Box4.rotate(axis=Z, angle=45deg)
  Box1_2 [FR4_epoxy] = Box4.duplicate_along_line(step=(comp_refletor-1.2mm, 0mm, 0mm), total=2)
  Cylinder1_3 = Cylinder9.copy()
  Cylinder9.rotate(axis=Z, angle=45deg)
  Cylinder1_8 [brass] = Cylinder9.duplicate_along_line(step=(comp_refletor-1.2mm, 0mm, 0mm), total=2)
  Cylinder3_3 = Cylinder10.copy()
  Cylinder2 = cylinder(axis=Z, base_centre=(0mm, 0mm, 0mm), radius=(1mm/2)*2.3, height=-dist_refletor)
  Cylinder2.move(0mm, -dist_central/2-cabo, 0mm)
  Cylinder2_1 = Cylinder2.duplicate_around_axis(axis=Z, angle=90deg, total=2)
  Cylinder2_ObjectFromFace2 = object_from(Cylinder2.face(-z end))
  Cylinder10.subtract(Cylinder2)
  Cylinder10.rotate(axis=Z, angle=45deg)
  Cylinder3_7 [brass] = Cylinder10.duplicate_along_line(step=(comp_refletor-1.2mm, 0mm, 0mm), total=2)
  Cylinder3_1_2 = Cylinder3_6.copy()
  Cylinder2_1_ObjectFromFace2 = object_from(Cylinder2_1.face(2 of 3))
  Cylinder3_6.subtract(Cylinder2_1)
  Cylinder3_6.rotate(axis=Z, angle=45deg)
  Cylinder3_1_4 [brass] = Cylinder3_6.duplicate_along_line(step=(comp_refletor-1.2mm, 0mm, 0mm), total=2)
  Cylinder1_7.rotate(axis=Z, angle=45deg)
  Cylinder1_1_3 [brass] = Cylinder1_7.duplicate_along_line(step=(comp_refletor-1.2mm, 0mm, 0mm), total=2)
  Rectangle14 = rectangle(corner=(-comp_curto_1/2, 0, 0mm), x_size=comp_curto_1, y_size=larg_curto)
  Rectangle3 = rectangle(corner=(0, 0, 0mm), x_size=comp_curto_2, y_size=larg_curto)
  Rectangle3.rotate(axis=Z, angle=45deg)
  Rectangle3.move(comp_curto_1/2, 0mm, 0mm)
  Rectangle3_1 = Rectangle3.duplicate_mirror(point=(0mm, 0mm, 0mm), normal=(-1mm, 0mm, 0mm))
  Rectangle14.unite(Rectangle3, Rectangle3_1)
  Rectangle14.move(0mm, pos_curto_1+dist_central/2, 0mm)
  Rectangle4 = rectangle(corner=(-larg_curto/2, -dist_central/2-cabo-1mm, 0mm), x_size=larg_curto, y_size=dist_central+cabo+1mm+pos_curto_1)
  Rectangle14.unite(Rectangle4)
  Rectangle14.move(0mm, 0mm, 1.2mm)
  Rectangle14.subtract(Cylinder1_3)
  Rectangle14.rotate(axis=Z, angle=45deg)
  Rectangle2_2 = Rectangle14.duplicate_along_line(step=(comp_refletor-1.2mm, 0mm, 0mm), total=2)
  Cylinder2_ObjectFromFace2.rotate(axis=Z, angle=45deg)
  Cylinder2_ObjectFromFace1_2 = Cylinder2_ObjectFromFace2.duplicate_along_line(step=(comp_refletor-1.2mm, 0mm, 0mm), total=2)
  Cylinder2_1_ObjectFromFace2.rotate(axis=Z, angle=45deg)
  Cylinder2_1_ObjectFromFace1_2 = Cylinder2_1_ObjectFromFace2.duplicate_along_line(step=(comp_refletor-1.2mm, 0mm, 0mm), total=2)
  Box5 [aluminum] = box(corner=(-comp_refletor/2, -comp_refletor/2, -dist_refletor), size=(comp_refletor, comp_refletor, 1.2mm))
  Box5.rotate(axis=Z, angle=45deg)
  Box5.subtract(Cylinder3_3, Cylinder3_1_2)
  Box6 = box(corner=(-comp_refletor/2, -comp_refletor/2, -dist_refletor), size=(comp_refletor, 1.2mm, refl_lat))
  Box6.rotate(axis=Z, angle=45deg)
  Box3_1, Box3_2, Box3_3 = Box6.duplicate_around_axis(axis=Z, angle=90deg, total=4)
  Box5.unite(Box6, Box3_1, Box3_2, Box3_3)
  Box5.rotate(axis=Z, angle=45deg)
  Box2_1 = Box5.duplicate_along_line(step=(comp_refletor-1.2mm, 0mm, 0mm), total=2)
  Box5.unite(Box2_1)
  Rectangle15 = rectangle(corner=(-comp_curto_1/2, 0, 0mm), x_size=comp_curto_1, y_size=larg_curto)
  Rectangle6 = rectangle(corner=(0, 0, 0mm), x_size=comp_curto_2, y_size=larg_curto)
  Rectangle6.rotate(axis=Z, angle=45deg)
  Rectangle6.move(comp_curto_1/2, 0mm, 0mm)
  Rectangle3_2 = Rectangle6.duplicate_mirror(point=(0mm, 0mm, 0mm), normal=(-1mm, 0mm, 0mm))
  Rectangle15.unite(Rectangle6, Rectangle3_2)
  Rectangle15.move(0mm, pos_curto_1+dist_central/2, 0mm)
  Rectangle7 = rectangle(corner=(-larg_curto/2, -dist_central/2-cabo-1mm, 0mm), x_size=larg_curto, y_size=dist_central+cabo+1mm+pos_curto_1)
  Rectangle15.unite(Rectangle7)
  Rectangle15.move(0mm, 0mm, 1.2mm)
  Cylinder4 = cylinder(axis=Z, base_centre=(0mm, 0mm, 1.5mm), radius=1mm/2, height=-dist_refletor-1.5mm)
  Cylinder4.move(0mm, -dist_central/2-cabo, 0mm)
  Cylinder1_4 = Cylinder4.copy()
  Rectangle15.subtract(Cylinder1_4)
  Cylinder4.delete()
  Rectangle15.rotate(axis=Z, angle=90deg)
  Rectangle17 = rectangle(corner=(-larg_curto/2, -loop_curto/2+.5mm, 1.2mm), x_size=larg_curto, y_size=loop_curto-1mm)
  Rectangle17.rotate(axis=Z, angle=90deg)
  Rectangle15.subtract(Rectangle17)
  Rectangle15.rotate(axis=Z, angle=45deg)
  Rectangle5_2 = Rectangle15.duplicate_along_line(step=(comp_refletor-1.2mm, 0mm, 0mm), total=2)
  Rectangle16 = rectangle(corner=(-larg_curto/2, -loop_curto/2-.5mm, 0mm), x_size=larg_curto, y_size=loop_curto+1mm)
  Rectangle16.rotate(axis=Z, angle=90deg)
  Rectangle16.rotate(axis=Z, angle=45deg)
  Rectangle10_2 = Rectangle16.duplicate_along_line(step=(comp_refletor-1.2mm, 0mm, 0mm), total=2)
  Cylinder11.rotate(axis=Z, angle=45deg)
  Cylinder5_6 [copper] = Cylinder11.duplicate_along_line(step=(comp_refletor-1.2mm, 0mm, 0mm), total=2)
  Cylinder5_5.rotate(axis=Z, angle=45deg)
  Cylinder5_1_3 [copper] = Cylinder5_5.duplicate_along_line(step=(comp_refletor-1.2mm, 0mm, 0mm), total=2)
  [Box5, Cylinder1_1_3, Cylinder1_7, Cylinder1_8, Cylinder3_1_4, Cylinder3_6, Cylinder3_7, Cylinder9, Cylinder10, Cylinder5_1_3, Cylinder5_5, Cylinder5_6, Cylinder11, Box1_2, Box4, Polyline1_5, Polyline3, Rectangle2_2, Rectangle5_2, Rectangle10_2, Rectangle14, Rectangle15, Rectangle16, Cylinder2_1_ObjectFromFace1_2, Cylinder2_1_ObjectFromFace2, Cylinder2_ObjectFromFace1_2, Cylinder2_ObjectFromFace2].move(X1, Y1, 0mm)
  [Box1, Box1_1, Box2, Box3, Box3_4, Cylinder1, Cylinder1_1, Cylinder1_1_2, Cylinder1_5, Cylinder1_6, Cylinder1_6_1, Cylinder3, Cylinder3_1, Cylinder3_1_3, Cylinder3_4, Cylinder3_5, Cylinder3_5_1, Cylinder5, Cylinder5_1, Cylinder5_1_2, Cylinder5_3, Cylinder5_4, Cylinder5_4_1, Cylinder6, Cylinder6_1, Cylinder7, Cylinder7_1, Cylinder8, Cylinder8_1, Cylinder2_1_ObjectFromFace1, Cylinder2_1_ObjectFromFace1_1, Cylinder2_ObjectFromFace1, Cylinder2_ObjectFromFace1_1, Polyline1, Polyline1_4, Polyline2, Polyline2_4, Rectangle2, Rectangle2_1, Rectangle5, Rectangle5_1, Rectangle10, Rectangle10_1, Rectangle11, Rectangle11_1, Rectangle12, Rectangle12_1, Rectangle13, Rectangle13_1].move(0mm, 0mm, 15mm)
  Box5.move_faces(MoveAlongNormalFlag=true OffsetDistance=dim_ref_3 FacesToMove=Box5.face(at (189.4, 0.6, -11.4), at (110.6, 0.6, -11.4), at (150, 65, -6.9), at (189.4, 71.6, -11.4)))
  Box5.move_faces(MoveAlongNormalFlag=true OffsetDistance=-dim_ref_3 FacesToMove=Box5.face(at (150, 72.8, -12), at (150, -0.6, -11.4)))
  Box7 = box(corner=(229.4mm, 0mm, (-18.8-2) mm), size=(-158.8mm, 65mm, 14.8mm))
  Box2.subtract(Box7)
  Box5.unite(Box2)
  Box5_1 = Box5.duplicate_mirror(point=(0mm, 0mm, 0mm), normal=(0mm, -1mm, 0mm))
  Box8 = box(corner=(-100mm, 175mm, -20mm), size=(500mm, -350mm, 2mm))
  Box5_1.subtract(Box8)
  Box5.unite(Box5_1)
  Polyline1_5_1 = Polyline1_5.duplicate_mirror(point=(0mm, 0mm, 0mm), normal=(0mm, -1mm, 0mm))
  Polyline3_1 = Polyline3.duplicate_mirror(point=(0mm, 0mm, 0mm), normal=(0mm, -1mm, 0mm))
  Rectangle2_2_1 = Rectangle2_2.duplicate_mirror(point=(0mm, 0mm, 0mm), normal=(0mm, -1mm, 0mm))
  Rectangle5_2_1 = Rectangle5_2.duplicate_mirror(point=(0mm, 0mm, 0mm), normal=(0mm, -1mm, 0mm))
  Rectangle10_2_1 = Rectangle10_2.duplicate_mirror(point=(0mm, 0mm, 0mm), normal=(0mm, -1mm, 0mm))
  Rectangle14_1 = Rectangle14.duplicate_mirror(point=(0mm, 0mm, 0mm), normal=(0mm, -1mm, 0mm))
  Rectangle15_1 = Rectangle15.duplicate_mirror(point=(0mm, 0mm, 0mm), normal=(0mm, -1mm, 0mm))
  Rectangle16_1 = Rectangle16.duplicate_mirror(point=(0mm, 0mm, 0mm), normal=(0mm, -1mm, 0mm))
  Polyline2_4_1 = Polyline2_4.duplicate_mirror(point=(0mm, 0mm, 0mm), normal=(0mm, -1mm, 0mm))
  Cylinder2_1_ObjectFromFace1_3 = Cylinder2_1_ObjectFromFace1.duplicate_mirror(point=(0mm, 0mm, 0mm), normal=(0mm, -1mm, 0mm))
  Cylinder2_1_ObjectFromFace1_1_1 = Cylinder2_1_ObjectFromFace1_1.duplicate_mirror(point=(0mm, 0mm, 0mm), normal=(0mm, -1mm, 0mm))
  Cylinder2_ObjectFromFace1_3 = Cylinder2_ObjectFromFace1.duplicate_mirror(point=(0mm, 0mm, 0mm), normal=(0mm, -1mm, 0mm))
  Cylinder2_ObjectFromFace1_1_1 = Cylinder2_ObjectFromFace1_1.duplicate_mirror(point=(0mm, 0mm, 0mm), normal=(0mm, -1mm, 0mm))
  Polyline2_5 = Polyline2.duplicate_mirror(point=(0mm, 0mm, 0mm), normal=(0mm, -1mm, 0mm))
  Rectangle11_2 = Rectangle11.duplicate_mirror(point=(0mm, 0mm, 0mm), normal=(0mm, -1mm, 0mm))
  Rectangle11_1_1 = Rectangle11_1.duplicate_mirror(point=(0mm, 0mm, 0mm), normal=(0mm, -1mm, 0mm))
  Rectangle12_2 = Rectangle12.duplicate_mirror(point=(0mm, 0mm, 0mm), normal=(0mm, -1mm, 0mm))
  Rectangle12_1_1 = Rectangle12_1.duplicate_mirror(point=(0mm, 0mm, 0mm), normal=(0mm, -1mm, 0mm))
  Rectangle13_2 = Rectangle13.duplicate_mirror(point=(0mm, 0mm, 0mm), normal=(0mm, -1mm, 0mm))
  Rectangle13_1_1 = Rectangle13_1.duplicate_mirror(point=(0mm, 0mm, 0mm), normal=(0mm, -1mm, 0mm))
  Box4_1 [FR4_epoxy] = Box4.duplicate_mirror(point=(0mm, 0mm, 0mm), normal=(0mm, -1mm, 0mm))
  Box3_5 [FR4_epoxy] = Box3.duplicate_mirror(point=(0mm, 0mm, 0mm), normal=(0mm, -1mm, 0mm))
  Box3_4_1 [FR4_epoxy] = Box3_4.duplicate_mirror(point=(0mm, 0mm, 0mm), normal=(0mm, -1mm, 0mm))
  Box1_2_1 [FR4_epoxy] = Box1_2.duplicate_mirror(point=(0mm, 0mm, 0mm), normal=(0mm, -1mm, 0mm))
  Cylinder10_1 [brass] = Cylinder10.duplicate_mirror(point=(0mm, 0mm, 0mm), normal=(0mm, -1mm, 0mm))
  Cylinder1_1_3_1 [brass] = Cylinder1_1_3.duplicate_mirror(point=(0mm, 0mm, 0mm), normal=(0mm, -1mm, 0mm))
  Cylinder1_7_1 [brass] = Cylinder1_7.duplicate_mirror(point=(0mm, 0mm, 0mm), normal=(0mm, -1mm, 0mm))
  Cylinder1_8_1 [brass] = Cylinder1_8.duplicate_mirror(point=(0mm, 0mm, 0mm), normal=(0mm, -1mm, 0mm))
  Cylinder3_1_4_1 [brass] = Cylinder3_1_4.duplicate_mirror(point=(0mm, 0mm, 0mm), normal=(0mm, -1mm, 0mm))
  Cylinder3_6_1 [brass] = Cylinder3_6.duplicate_mirror(point=(0mm, 0mm, 0mm), normal=(0mm, -1mm, 0mm))
  Cylinder3_7_1 [brass] = Cylinder3_7.duplicate_mirror(point=(0mm, 0mm, 0mm), normal=(0mm, -1mm, 0mm))
  Cylinder9_1 [brass] = Cylinder9.duplicate_mirror(point=(0mm, 0mm, 0mm), normal=(0mm, -1mm, 0mm))
  Cylinder5_4_2 [copper] = Cylinder5_4.duplicate_mirror(point=(0mm, 0mm, 0mm), normal=(0mm, -1mm, 0mm))
  Cylinder5_4_1_1 [copper] = Cylinder5_4_1.duplicate_mirror(point=(0mm, 0mm, 0mm), normal=(0mm, -1mm, 0mm))
  Cylinder6_2 [copper] = Cylinder6.duplicate_mirror(point=(0mm, 0mm, 0mm), normal=(0mm, -1mm, 0mm))
  Cylinder6_1_1 [copper] = Cylinder6_1.duplicate_mirror(point=(0mm, 0mm, 0mm), normal=(0mm, -1mm, 0mm))
  Cylinder7_2 [copper] = Cylinder7.duplicate_mirror(point=(0mm, 0mm, 0mm), normal=(0mm, -1mm, 0mm))
  Cylinder7_1_1 [copper] = Cylinder7_1.duplicate_mirror(point=(0mm, 0mm, 0mm), normal=(0mm, -1mm, 0mm))
  Cylinder8_2 [copper] = Cylinder8.duplicate_mirror(point=(0mm, 0mm, 0mm), normal=(0mm, -1mm, 0mm))
  Cylinder8_1_1 [copper] = Cylinder8_1.duplicate_mirror(point=(0mm, 0mm, 0mm), normal=(0mm, -1mm, 0mm))
  Cylinder3_5_2 [copper] = Cylinder3_5.duplicate_mirror(point=(0mm, 0mm, 0mm), normal=(0mm, -1mm, 0mm))
  Cylinder3_5_1_1 [copper] = Cylinder3_5_1.duplicate_mirror(point=(0mm, 0mm, 0mm), normal=(0mm, -1mm, 0mm))
  Cylinder1_6_2 [copper] = Cylinder1_6.duplicate_mirror(point=(0mm, 0mm, 0mm), normal=(0mm, -1mm, 0mm))
  Cylinder1_6_1_1 [copper] = Cylinder1_6_1.duplicate_mirror(point=(0mm, 0mm, 0mm), normal=(0mm, -1mm, 0mm))
  Circle1 = circle(normal=Z, centre=(218.20729mm, 124.20729mm, -20mm), radius=1.15mm)
  Circle1_1 = Circle1.duplicate_along_line(step=(-128mm, 0mm, 0mm), total=2)
  Circle2 = circle(normal=Z, centre=(306.90955mm, 8.9095454mm, -20mm), radius=1.15mm)
  Circle2_1 = Circle2.duplicate_along_line(step=(-298mm, 0mm, 0mm), total=2)
  Cylinder5_6_1 [copper] = Cylinder5_6.duplicate_mirror(point=(0mm, 0mm, 0mm), normal=(0mm, -1mm, 0mm))
  Cylinder5_1_3_1 [copper] = Cylinder5_1_3.duplicate_mirror(point=(0mm, 0mm, 0mm), normal=(0mm, -1mm, 0mm))
  Cylinder11_1 [copper] = Cylinder11.duplicate_mirror(point=(0mm, 0mm, 0mm), normal=(0mm, -1mm, 0mm))
  Cylinder5_5_1 [copper] = Cylinder5_5.duplicate_mirror(point=(0mm, 0mm, 0mm), normal=(0mm, -1mm, 0mm))
  Cylinder12 = cylinder(axis=Z, base_centre=(192.7234mm, -29.476598mm, -20mm), radius=1.75mm, height=4mm)
  Cylinder12_1 = Cylinder12.duplicate_along_line(step=(0mm, -6.6468037mm, 0mm), total=2)
  Cylinder12_2 = Cylinder12.duplicate_along_line(step=(-78.8mm, 0mm, 0mm), total=2)
  Cylinder12_1_1 = Cylinder12_1.duplicate_along_line(step=(-78.8mm, 0mm, 0mm), total=2)
  Cylinder12_3 = Cylinder12.duplicate_along_line(step=(25.483883mm, -86.316117mm, 0mm), total=2)
  Cylinder12_3_1 = Cylinder12_3.duplicate_along_line(step=(0mm, -8.4145707mm, 0mm), total=2)
  Cylinder12_3_2 = Cylinder12_3.duplicate_along_line(step=(-128mm, 0mm, 0mm), total=2)
  Cylinder12_3_1_1 = Cylinder12_3_1.duplicate_along_line(step=(-128mm, 0mm, 0mm), total=2)
  Box5.subtract(Cylinder12, Cylinder12_1, Cylinder12_1_1, Cylinder12_2, Cylinder12_3, Cylinder12_3_1, Cylinder12_3_1_1, Cylinder12_3_2)
  Circle2_2 = Circle2.duplicate_along_line(step=(-5.1159077e-13mm, -17.819091mm, 0mm), total=2)
  Circle2_1_1 = Circle2_1.duplicate_along_line(step=(-5.1691984e-13mm, -17.819091mm, 0mm), total=2)
  Circle1_2 = Circle1.duplicate_along_line(step=(0mm, -8.4145707mm, 0mm), total=2)
  Circle1_2_1 = Circle1_2.duplicate_along_line(step=(-128mm, 0mm, 0mm), total=2)
  Circle1_3 = Circle1.duplicate_along_line(step=(-5.6843419e-14mm, -240mm, 0mm), total=2)
  Circle1_2_2 = Circle1_2.duplicate_along_line(step=(-5.6843419e-14mm, -240mm, 0mm), total=2)
  Circle1_1_1 = Circle1_1.duplicate_along_line(step=(0mm, -240mm, 7.1054274e-15mm), total=2)
  Circle1_2_1_1 = Circle1_2_1.duplicate_along_line(step=(0mm, -240mm, 7.1054274e-15mm), total=2)
  Cylinder2_1_ObjectFromFace2_1 = Cylinder2_1_ObjectFromFace2.duplicate_along_line(step=(0mm, -6.6468037mm, 0mm), total=2)
  Cylinder2_1_ObjectFromFace1_2_1 = Cylinder2_1_ObjectFromFace1_2.duplicate_along_line(step=(0mm, -6.6468037mm, 0mm), total=2)
  Cylinder2_1_ObjectFromFace2_2 = Cylinder2_1_ObjectFromFace2.duplicate_along_line(step=(0mm, -65.6mm, 0mm), total=2)
  Cylinder2_1_ObjectFromFace1_2_2 = Cylinder2_1_ObjectFromFace1_2.duplicate_along_line(step=(0mm, -65.6mm, 0mm), total=2)
  Cylinder2_1_ObjectFromFace2_3 = Cylinder2_1_ObjectFromFace2.duplicate_along_line(step=(0mm, -72.246804mm, 0mm), total=2)
  Cylinder2_1_ObjectFromFace1_2_3 = Cylinder2_1_ObjectFromFace1_2.duplicate_along_line(step=(0mm, -72.246804mm, 0mm), total=2)
  coordinate_system RelativeCS1 = origin=(150.6mm, -0.6mm, -4mm) x=(1mm, 0mm, 0mm) y=(0mm, 1mm, 0mm)
  RadiatingSurface [vacuum] = region(absolute_offset=45.6621mm on all sides) in RelativeCS1
boundaries and excitations:
  FiniteCond1: Finite Conductivity Objects=[Cylinder2_1_ObjectFromFace1, Cylinder2_1_ObjectFromFace1_1, Cylinder2_1_ObjectFromFace1_1_1, Cylinder2_1_ObjectFromFace1_3, Cylinder2_ObjectFromFace1, Cylinder2_ObjectFromFace1_1, Cylinder2_ObjectFromFace1_1_1, Cylinder2_ObjectFromFace1_2, Cylinder2_ObjectFromFace1_3, Cylinder2_ObjectFromFace2, Polyline1, Polyline1_4, Polyline1_5, Polyline1_5_1, Polyline2, Polyline2_4, Polyline2_4_1, Polyline2_5, Polyline3, Polyline3_1, Rectangle2, Rectangle2_1, Rectangle2_2, Rectangle2_2_1, Rectangle5, Rectangle5_1, Rectangle5_2, Rectangle5_2_1, Rectangle10, Rectangle10_1, Rectangle10_2, Rectangle10_2_1, Rectangle11, Rectangle11_1, Rectangle11_1_1, Rectangle11_2, Rectangle12, Rectangle12_1, Rectangle12_1_1, Rectangle12_2, Rectangle13, Rectangle13_1, Rectangle13_1_1, Rectangle13_2, Rectangle14, Rectangle14_1, Rectangle15, Rectangle15_1, Rectangle16, Rectangle16_1] UseMaterial Material=copper IsInternal
  AutoOpen1: Radiation Objects=RadiatingSurface
  3g-1: Lumped Port Objects=Cylinder2_1_ObjectFromFace2 LumpedPortType=Modal Modes{Mode1{IntLine{(113.9234, 36.123402, -20) -> (114.73657, 36.936575, -20)} CharImp=Zpi RenormImp=40ohm}} Impedance=50ohm
  3g-2: Lumped Port Objects=Cylinder2_1_ObjectFromFace1_2 LumpedPortType=Modal Modes{Mode1{IntLine{(192.7234, 36.123402, -20) -> (193.53657, 36.936575, -20)} CharImp=Zpi RenormImp=50ohm}} Impedance=50ohm
  2g-1: Lumped Port Objects=Circle1 LumpedPortType=Modal Modes{Mode1{IntLine{(218.20729, 124.20729, -20) -> (219.02046, 125.02046, -20)} CharImp=Zpi RenormImp=50ohm}} Impedance=50ohm
  2g-2: Lumped Port Objects=Circle1_1 LumpedPortType=Modal Modes{Mode1{IntLine{(90.207285, 124.20729, -20) -> (91.020458, 125.02046, -20)} CharImp=Zpi RenormImp=50ohm}} Impedance=50ohm
  1g-1: Lumped Port Objects=Circle2 LumpedPortType=Modal Modes{Mode1{IntLine{(306.90955, 8.9095454, -20) -> (307.72272, 9.7227182, -20)} CharImp=Zpi RenormImp=50ohm}} Impedance=50ohm
  1g-2: Lumped Port Objects=Circle2_1 LumpedPortType=Modal Modes{Mode1{IntLine{(8.9095454, 8.9095454, -20) -> (9.7227182, 9.7227182, -20)} CharImp=Zpi RenormImp=50ohm}} Impedance=50ohm
  1g-3: Lumped Port Objects=Circle2_2 LumpedPortType=Modal Modes{Mode1{IntLine{(306.90955, -8.9095454, -20) -> (307.72272, -8.0963726, -20)} CharImp=Zpi RenormImp=50ohm}} Impedance=50ohm
  1g-6: Lumped Port Objects=Circle2_1_1 LumpedPortType=Modal Modes{Mode1{IntLine{(8.9095454, -8.9095454, -20) -> (9.7227182, -8.0963726, -20)} CharImp=Zpi RenormImp=50ohm}} Impedance=50ohm
  2g-3: Lumped Port Objects=Circle1_2 LumpedPortType=Modal Modes{Mode1{IntLine{(218.20729, 115.79271, -20) -> (219.02046, 116.60589, -20)} CharImp=Zpi RenormImp=50ohm}} Impedance=50ohm
  2g-4: Lumped Port Objects=Circle1_2_1 LumpedPortType=Modal Modes{Mode1{IntLine{(90.207285, 115.79271, -20) -> (91.020458, 116.60589, -20)} CharImp=Zpi RenormImp=50ohm}} Impedance=50ohm
  2g-5: Lumped Port Objects=Circle1_3 LumpedPortType=Modal Modes{Mode1{IntLine{(218.20729, -115.79271, -20) -> (219.02046, -114.97954, -20)} CharImp=Zpi RenormImp=50ohm}} Impedance=50ohm
  2g-6: Lumped Port Objects=Circle1_2_2 LumpedPortType=Modal Modes{Mode1{IntLine{(218.20729, -124.20729, -20) -> (219.02046, -123.39411, -20)} CharImp=Zpi RenormImp=50ohm}} Impedance=50ohm
  2g-7: Lumped Port Objects=Circle1_1_1 LumpedPortType=Modal Modes{Mode1{IntLine{(90.207285, -115.79271, -20) -> (91.020458, -114.97954, -20)} CharImp=Zpi RenormImp=50ohm}} Impedance=50ohm
  2g-8: Lumped Port Objects=Circle1_2_1_1 LumpedPortType=Modal Modes{Mode1{IntLine{(90.207285, -124.20729, -20) -> (91.020458, -123.39411, -20)} CharImp=Zpi RenormImp=50ohm}} Impedance=50ohm
  3g-3: Lumped Port Objects=Cylinder2_1_ObjectFromFace2_1 LumpedPortType=Modal Modes{Mode1{IntLine{(113.9234, 29.476598, -20) -> (114.73657, 30.289771, -20)} CharImp=Zpi RenormImp=40ohm}} Impedance=50ohm
  3g-4: Lumped Port Objects=Cylinder2_1_ObjectFromFace1_2_1 LumpedPortType=Modal Modes{Mode1{IntLine{(192.7234, 29.476598, -20) -> (193.53657, 30.289771, -20)} CharImp=Zpi RenormImp=50ohm}} Impedance=50ohm
  3g-5: Lumped Port Objects=Cylinder2_1_ObjectFromFace2_2 LumpedPortType=Modal Modes{Mode1{IntLine{(113.9234, -29.476598, -20) -> (114.73657, -28.663425, -20)} CharImp=Zpi RenormImp=40ohm}} Impedance=50ohm
  3g-6: Lumped Port Objects=Cylinder2_1_ObjectFromFace1_2_2 LumpedPortType=Modal Modes{Mode1{IntLine{(192.7234, -29.476598, -20) -> (193.53657, -28.663425, -20)} CharImp=Zpi RenormImp=50ohm}} Impedance=50ohm
  3g-7: Lumped Port Objects=Cylinder2_1_ObjectFromFace2_3 LumpedPortType=Modal Modes{Mode1{IntLine{(113.9234, -36.123402, -20) -> (114.73657, -35.310229, -20)} CharImp=Zpi RenormImp=40ohm}} Impedance=50ohm
  3g-8: Lumped Port Objects=Cylinder2_1_ObjectFromFace1_2_3 LumpedPortType=Modal Modes{Mode1{IntLine{(192.7234, -36.123402, -20) -> (193.53657, -35.310229, -20)} CharImp=Zpi RenormImp=50ohm}} Impedance=50ohm
setups:
  Setup1: HfssDriven MultipleAdaptiveFreqsSetup{AdaptAt{Frequency=880MHz Delta=0.02} AdaptAt{Frequency=2.2GHz Delta=0.02} AdaptAt{Frequency=3.5GHz Delta=0.02}} MaximumPasses=5 MinimumPasses=1 MinimumConvergedPasses=1 PercentRefinement=30 BasisOrder=1 PortAccuracy=2 DrivenSolverType="Auto Select Direct/Iterative" InfiniteSphereSetup=0
    sweep Sweep1: 690MHz to 3800MHz, 201 points; disabled Type=Interpolating InterpTolerance=0.5 InterpMaxSolns=250 InterpUsePortImped=false PassivityErrorTolerance=0.0001
source amplitudes:
  3g-1:1, 3g-3:1: port3g1 0deg
  3g-2:1: port3g2 0deg
  2g-1:1: port2g1 0deg
  2g-2:1: port2g2 0deg
  1g-1:1: port1g1 0deg
  1g-2:1: port1g2 0deg
  1g-3:1: port1g3 0deg
  1g-6:1: port1g4 0deg
  2g-3:1: port2g3 0deg
  2g-4:1: port2g4 0deg
  2g-5:1: port2g5 0deg
  2g-6:1: port2g6 0deg
  2g-7:1: port2g7 0deg
  2g-8:1: port2g8 0deg
  3g-4:1: port3g4 0deg
  3g-5:1: port3g5 0deg
  3g-6:1: port3g6 0deg
  3g-7:1: port3g7 0deg
  3g-8:1: port3g8 0deg
radiation setups:
  Infinite Sphere1: Infinite Sphere Theta=-180deg..180deg step 1deg Phi=-180deg..180deg step 1deg CoordSystem=RelativeCS1
  3D: Infinite Sphere Theta=0deg..180deg step 2deg Phi=-180deg..180deg step 2deg CoordSystem=RelativeCS1
  Elevation: Infinite Sphere Theta=-180deg..180deg step 1deg Phi=0deg..90deg step 90deg CoordSystem=RelativeCS1
  Azimuth: Infinite Sphere Theta=90deg..90deg step 0deg Phi=-180deg..180deg step 1deg CoordSystem=RelativeCS1
field plots:
  Mag_E1: E Field over Box5.face(at (190.973, -29.4766, -19.4), at (190.973, -36.1234, -19.4), at (112.173, -36.1234, -19.4), at (112.173, -29.4766, -19.4), at (216.457, -115.793, -19.4), at (216.457, -124.207, -19.4), at (88.4573, -124.207, -19.4), at (88.4573, -115.793, -19.4), at (150, -87.2, -18), at (22.2, -120, -6.5), at (277.8, -120, -6.5), at (279, -119.4, -6.5)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) on Setup1 : LastAdaptive at Freq=0.88GHz Phase=0deg
  Mag_Jsurf1: Jsurf over Box5.face(at (190.973, -29.4766, -19.4), at (190.973, -36.1234, -19.4), at (112.173, -36.1234, -19.4), at (112.173, -29.4766, -19.4), at (216.457, -115.793, -19.4), at (216.457, -124.207, -19.4), at (88.4573, -124.207, -19.4), at (88.4573, -115.793, -19.4), at (150, -87.2, -18), at (22.2, -120, -6.5), at (277.8, -120, -6.5), at (279, -119.4, -6.5)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) on Setup1 : LastAdaptive at Freq=0.88GHz Phase=0deg
reports:
  XY Plot 1: dB(S(3g-1,3g-1))-2 vs Freq on Setup1 : Sweep1
  Smith Chart 1: S(3g-1,3g-1) on Setup1 : Sweep1 [Freq=all]
  Gain Plot 1: dB(GainTotal) vs Phi, Theta on Setup1 : LastAdaptive, Infinite Sphere1 [Freq=0.88GHz]
  S Parameter Plot 1: dB(S(1g-1,1g-1)), dB(S(2g-1,2g-1)), dB(S(3g-1,3g-1)) vs Freq on Setup1 : Sweep1
